* NGSPICE file created from ESD_array_layout.ext - technology: gf180mcuD

.subckt ppolyf_u_9H3LNU a_n4000_1000# a_n4000_n1102# w_n4216_n1318#
X0 a_n4000_1000# a_n4000_n1102# w_n4216_n1318# ppolyf_u r_width=40u r_length=10u
.ends

.subckt diode_nd2ps_06v0_MV3SZ3 a_116_n1000# a_2348_n1000# a_n4348_n1000# a_n4500_n1152#
+ a_n2116_n1000#
D0 a_n4500_n1152# a_116_n1000# diode_nd2ps_06v0 pj=40u area=99.99999p
D1 a_n4500_n1152# a_2348_n1000# diode_nd2ps_06v0 pj=40u area=99.99999p
D2 a_n4500_n1152# a_n4348_n1000# diode_nd2ps_06v0 pj=40u area=99.99999p
D3 a_n4500_n1152# a_n2116_n1000# diode_nd2ps_06v0 pj=40u area=99.99999p
.ends

.subckt diode_pd2nw_06v0_5DG9HC a_n2108_n1000# a_2324_n1000# w_n4500_n1176# a_n4324_n1000#
+ a_108_n1000#
D0 a_2324_n1000# w_n4500_n1176# diode_pd2nw_06v0 pj=40u area=99.99999p
D1 a_n4324_n1000# w_n4500_n1176# diode_pd2nw_06v0 pj=40u area=99.99999p
D2 a_n2108_n1000# w_n4500_n1176# diode_pd2nw_06v0 pj=40u area=99.99999p
D3 a_108_n1000# w_n4500_n1176# diode_pd2nw_06v0 pj=40u area=99.99999p
.ends

.subckt io_secondary_5p0 ASIG5V to_gate VDD VSS
Xppolyf_u_9H3LNU_0 ASIG5V to_gate VDD ppolyf_u_9H3LNU
Xdiode_nd2ps_06v0_MV3SZ3_0 to_gate to_gate to_gate VSS to_gate diode_nd2ps_06v0_MV3SZ3
Xdiode_pd2nw_06v0_5DG9HC_0 to_gate to_gate VDD to_gate to_gate diode_pd2nw_06v0_5DG9HC
.ends

.subckt ESD_array_layout VDD VSS
Xio_secondary_5p0_0 io_secondary_5p0_0/ASIG5V io_secondary_5p0_0/to_gate VDD VSS io_secondary_5p0
Xio_secondary_5p0_1 io_secondary_5p0_1/ASIG5V io_secondary_5p0_1/to_gate VDD VSS io_secondary_5p0
Xio_secondary_5p0_2 io_secondary_5p0_2/ASIG5V io_secondary_5p0_2/to_gate VDD VSS io_secondary_5p0
Xio_secondary_5p0_3 io_secondary_5p0_3/ASIG5V io_secondary_5p0_3/to_gate VDD VSS io_secondary_5p0
Xio_secondary_5p0_4 io_secondary_5p0_4/ASIG5V io_secondary_5p0_4/to_gate VDD VSS io_secondary_5p0
.ends
