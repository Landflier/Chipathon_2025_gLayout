** sch_path: /home/vasil/Downloads/SSCS_PICO_2025/src/design_mag/padring_secondary_ESD_array/lvs/ESD_array_schematic.sch
.subckt ESD_array_schematic V_LO V_LO_b V_RF V_RF_b I_bias VSS VDD
*.PININFO V_LO:I V_LO_b:I V_RF:I V_RF_b:I I_bias:I VSS:I VDD:I
XIO1 VDD net1 V_LO VSS io_secondary_5p0
XIO2 VDD net2 I_bias VSS io_secondary_5p0
XIO3 VDD net3 V_LO_b VSS io_secondary_5p0
XIO4 VDD net4 V_RF VSS io_secondary_5p0
XIO5 VDD net5 V_RF_b VSS io_secondary_5p0
.ends

* expanding   symbol:
*+  /home/vasil/Downloads/SSCS_PICO_2025/src/design_padring/Chipathon2025_pads/xschem/symbols/io_secondary_5p0/io_secondary_5p0.sym # of pins=4
** sym_path: /home/vasil/Downloads/SSCS_PICO_2025/src/design_padring/Chipathon2025_pads/xschem/symbols/io_secondary_5p0/io_secondary_5p0.sym
** sch_path: /home/vasil/Downloads/SSCS_PICO_2025/src/design_padring/Chipathon2025_pads/xschem/symbols/io_secondary_5p0/io_secondary_5p0.sch
.subckt io_secondary_5p0 VDD to_gate ASIG5V VSS

*.PININFO VSS:B VDD:B to_gate:B ASIG5V:B
D1 to_gate VDD diode_pd2nw_06v0 area='10u * 10u ' pj='2*10u + 2*10u ' m=4
XR1 to_gate ASIG5V VDD ppolyf_u r_width=40e-6 r_length=10e-6 m=1
D2 VSS to_gate diode_nd2ps_06v0 area='10u * 10u ' pj='2*10u + 2*10u ' m=4
.ends

.end
