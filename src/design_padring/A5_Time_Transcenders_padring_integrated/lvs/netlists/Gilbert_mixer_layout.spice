* NGSPICE file created from Gilbert_mixer_layout.ext - technology: gf180mcuD

.subckt ppolyf_u_1k_DB8C7L a_n520_n192# a_n240_1192# a_n732_n1526# a_n240_70# a_n520_1192#
+ a_n240_n1314# a_320_n1314# a_40_n192# a_320_n192# a_n520_70# a_n520_n1314# a_320_70#
+ a_n240_n192# a_40_70# a_40_1192# a_40_n1314# a_320_1192#
X0 a_n520_1192# a_n520_70# a_n732_n1526# ppolyf_u_1k r_width=1u r_length=5u
X1 a_n240_1192# a_n240_70# a_n732_n1526# ppolyf_u_1k r_width=1u r_length=5u
X2 a_40_1192# a_40_70# a_n732_n1526# ppolyf_u_1k r_width=1u r_length=5u
X3 a_320_n192# a_320_n1314# a_n732_n1526# ppolyf_u_1k r_width=1u r_length=5u
X4 a_320_1192# a_320_70# a_n732_n1526# ppolyf_u_1k r_width=1u r_length=5u
X5 a_n240_n192# a_n240_n1314# a_n732_n1526# ppolyf_u_1k r_width=1u r_length=5u
X6 a_40_n192# a_40_n1314# a_n732_n1526# ppolyf_u_1k r_width=1u r_length=5u
X7 a_n520_n192# a_n520_n1314# a_n732_n1526# ppolyf_u_1k r_width=1u r_length=5u
.ends

.subckt Gilbert_mixer_loading_stage m1_168_2735# m1_168_194# VSUBS
Xppolyf_u_1k_DB8C7L_0 m1_170_1346# m1_459_2748# VSUBS m1_170_1346# m1_168_2735# m1_459_192#
+ VSUBS m1_741_1366# m1_730_1578# m1_181_1461# m1_168_194# m1_741_1366# m1_181_1461#
+ m1_730_1578# m1_459_2748# m1_459_192# VSUBS ppolyf_u_1k_DB8C7L
.ends

.subckt Unnamed_e3a0da27 m4_n620_n620# m4_n500_n500#
X0 m4_n500_n500# m4_n620_n620# cap_mim_2f0_m4m5_noshield c_width=5u c_length=5u
.ends

.subckt cmirror_interdigitized a_n1412_n50# w_n2485_n1240# a_n2168_n570#
X0 a_n1412_n50# a_n2168_n570# w_n2485_n1240# w_n2485_n1240# pfet_03v3 ad=0.23p pd=1.42u as=0.23p ps=1.42u w=0.5u l=0.4u M=12
X1 w_n2485_n1240# a_n2168_n570# a_n2168_n570# w_n2485_n1240# pfet_03v3 ad=0.495p pd=2.98u as=0.23p ps=1.42u w=0.5u l=0.4u M=4
.ends

.subckt pmos_Cmirror_with_decap$1 I_BIAS cmirror_interdigitized_0/a_n1412_n50# Unnamed_e3a0da27_0/m4_n500_n500#
+ Unnamed_e3a0da27_0/m4_n620_n620#
XUnnamed_e3a0da27_0 Unnamed_e3a0da27_0/m4_n620_n620# Unnamed_e3a0da27_0/m4_n500_n500#
+ Unnamed_e3a0da27
Xcmirror_interdigitized_0 cmirror_interdigitized_0/a_n1412_n50# Unnamed_e3a0da27_0/m4_n500_n500#
+ Unnamed_e3a0da27_0/m4_n620_n620# cmirror_interdigitized
.ends

.subckt Unnamed_a96b0a34 m4_n620_n620# m4_n500_n500#
X0 m4_n500_n500# m4_n620_n620# cap_mim_2f0_m4m5_noshield c_width=5u c_length=5u
.ends

.subckt cmirror_interdigitized$4 a_n3932_n75# a_n4280_n495# a_n4540_n809#
X0 a_n4540_n809# a_n4280_n495# a_n4280_n495# a_n4540_n809# nfet_03v3 ad=0.345p pd=1.67u as=0.345p ps=1.67u w=0.75u l=1u M=20
X1 a_n3932_n75# a_n4280_n495# a_n4540_n809# a_n4540_n809# nfet_03v3 ad=0.345p pd=1.67u as=0.7425p ps=3.48u w=0.75u l=1u M=2
.ends

.subckt nmos4_Cmirror_with_decap via_array_6f2c13fe$7_0/m2_n100_n100# Unnamed_a96b0a34_0/m4_n620_n620#
+ VSUBS
XUnnamed_a96b0a34_0 Unnamed_a96b0a34_0/m4_n620_n620# VSUBS Unnamed_a96b0a34
Xcmirror_interdigitized$4_0 via_array_6f2c13fe$7_0/m2_n100_n100# Unnamed_a96b0a34_0/m4_n620_n620#
+ VSUBS cmirror_interdigitized$4
.ends

.subckt Unnamed_ba8f6150 m4_n620_n620# m4_n500_n500#
X0 m4_n500_n500# m4_n620_n620# cap_mim_2f0_m4m5_noshield c_width=5u c_length=5u
.ends

.subckt cmirror_interdigitized$2 a_n2410_n75# a_n2360_n495# a_n2620_n809#
X0 a_n2620_n809# a_n2360_n495# a_n2410_n75# a_n2620_n809# nfet_03v3 ad=0.345p pd=1.67u as=0.345p ps=1.67u w=0.75u l=1u M=10
X1 a_n2360_n495# a_n2360_n495# a_n2620_n809# a_n2620_n809# nfet_03v3 ad=0.345p pd=1.67u as=0.345p ps=1.67u w=0.75u l=1u M=2
.ends

.subckt nmos2_Cmirror_with_decap Unnamed_ba8f6150_0/m4_n620_n620# via_array_6f2c13fe$5_0/m2_200_n100#
+ VSUBS
XUnnamed_ba8f6150_0 Unnamed_ba8f6150_0/m4_n620_n620# VSUBS Unnamed_ba8f6150
Xcmirror_interdigitized$2_0 via_array_6f2c13fe$5_0/m2_200_n100# Unnamed_ba8f6150_0/m4_n620_n620#
+ VSUBS cmirror_interdigitized$2
.ends

.subckt Unnamed_2e9f948d m4_n620_n620# m4_n500_n500#
X0 m4_n500_n500# m4_n620_n620# cap_mim_2f0_m4m5_noshield c_width=5u c_length=5u
.ends

.subckt cmirror_interdigitized$3 a_n824_n495# a_n1084_n809# a_n874_n75#
X0 a_n874_n75# a_n824_n495# a_n1084_n809# a_n1084_n809# nfet_03v3 ad=0.7425p pd=3.48u as=0.345p ps=1.67u w=0.75u l=1u M=2
X1 a_n824_n495# a_n824_n495# a_n1084_n809# a_n1084_n809# nfet_03v3 ad=0.345p pd=1.67u as=0.345p ps=1.67u w=0.75u l=1u M=2
.ends

.subckt nmos3_Cmirror_with_decap via_array_6f2c13fe$5$1_0/m2_n100_n100# Unnamed_2e9f948d_0/m4_n620_n620#
+ VSUBS
XUnnamed_2e9f948d_0 Unnamed_2e9f948d_0/m4_n620_n620# VSUBS Unnamed_2e9f948d
Xcmirror_interdigitized$3_0 Unnamed_2e9f948d_0/m4_n620_n620# VSUBS via_array_6f2c13fe$5$1_0/m2_n100_n100#
+ cmirror_interdigitized$3
.ends

.subckt Unnamed_40a499cb m4_n620_n620# m4_n500_n500#
X0 m4_n500_n500# m4_n620_n620# cap_mim_2f0_m4m5_noshield c_width=5u c_length=5u
.ends

.subckt cmirror_interdigitized$1 a_n2410_n75# a_n2360_n495# a_n2620_n809#
X0 a_n2620_n809# a_n2360_n495# a_n2410_n75# a_n2620_n809# nfet_03v3 ad=0.345p pd=1.67u as=0.345p ps=1.67u w=0.75u l=1u M=10
X1 a_n2360_n495# a_n2360_n495# a_n2620_n809# a_n2620_n809# nfet_03v3 ad=0.345p pd=1.67u as=0.345p ps=1.67u w=0.75u l=1u M=2
.ends

.subckt nmos1_Cmirror_with_decap Unnamed_40a499cb_0/m4_n620_n620# via_array_6f2c13fe$3_0/m2_200_n100#
+ VSUBS
XUnnamed_40a499cb_0 Unnamed_40a499cb_0/m4_n620_n620# VSUBS Unnamed_40a499cb
Xcmirror_interdigitized$1_0 via_array_6f2c13fe$3_0/m2_200_n100# Unnamed_40a499cb_0/m4_n620_n620#
+ VSUBS cmirror_interdigitized$1
.ends

.subckt Biasing_Network nmos2_Cmirror_with_decap_0/via_array_6f2c13fe$5_0/m2_200_n100#
+ nmos3_Cmirror_with_decap_0/via_array_6f2c13fe$5$1_0/m2_n100_n100# pmos_Cmirror_with_decap$1_0/Unnamed_e3a0da27_0/m4_n500_n500#
+ nmos4_Cmirror_with_decap_0/via_array_6f2c13fe$7_0/m2_n100_n100# nmos4_Cmirror_with_decap_0/Unnamed_a96b0a34_0/m4_n620_n620#
+ pmos_Cmirror_with_decap$1_0/Unnamed_e3a0da27_0/m4_n620_n620# m3_n9974_n6121# nmos1_Cmirror_with_decap_0/via_array_6f2c13fe$3_0/m2_200_n100#
+ VSUBS
Xpmos_Cmirror_with_decap$1_0 pmos_Cmirror_with_decap$1_0/I_BIAS m3_n9974_n6121# pmos_Cmirror_with_decap$1_0/Unnamed_e3a0da27_0/m4_n500_n500#
+ pmos_Cmirror_with_decap$1_0/Unnamed_e3a0da27_0/m4_n620_n620# pmos_Cmirror_with_decap$1
Xnmos4_Cmirror_with_decap_0 nmos4_Cmirror_with_decap_0/via_array_6f2c13fe$7_0/m2_n100_n100#
+ nmos4_Cmirror_with_decap_0/Unnamed_a96b0a34_0/m4_n620_n620# VSUBS nmos4_Cmirror_with_decap
Xnmos2_Cmirror_with_decap_0 m3_n9974_n6121# nmos2_Cmirror_with_decap_0/via_array_6f2c13fe$5_0/m2_200_n100#
+ VSUBS nmos2_Cmirror_with_decap
Xnmos3_Cmirror_with_decap_0 nmos3_Cmirror_with_decap_0/via_array_6f2c13fe$5$1_0/m2_n100_n100#
+ m3_n9974_n6121# VSUBS nmos3_Cmirror_with_decap
Xnmos1_Cmirror_with_decap_0 m3_n9974_n6121# nmos1_Cmirror_with_decap_0/via_array_6f2c13fe$3_0/m2_200_n100#
+ VSUBS nmos1_Cmirror_with_decap
.ends

.subckt LO_diff_pairs_interdigitized a_n2222_n400# a_n2878_n1500# a_n2578_n448# a_n2822_n400#
+ a_n3106_n400# a_n2522_n400# a_n3316_n1664#
X0 a_n2522_n400# a_n2578_n448# a_n2822_n400# a_n3316_n1664# nfet_03v3 ad=2.44p pd=5.22u as=2.44p ps=5.22u w=4u l=0.28u M=5
X1 a_n3106_n400# a_n2578_n448# a_n2222_n400# a_n3316_n1664# nfet_03v3 ad=2.44p pd=5.22u as=2.44p ps=5.22u w=4u l=0.28u M=5
X2 a_n2822_n400# a_n2878_n1500# a_n3106_n400# a_n3316_n1664# nfet_03v3 ad=2.44p pd=5.22u as=2.44p ps=5.22u w=4u l=0.28u M=5
X3 a_n2222_n400# a_n2878_n1500# a_n2522_n400# a_n3316_n1664# nfet_03v3 ad=2.44p pd=5.22u as=2.44p ps=5.22u w=4u l=0.28u M=5
.ends

.subckt RF_diff_pair$1 a_3384_n849# a_3440_n321# a_3156_n321# a_n628_n849# a_n572_n321#
+ a_n1750_n1013# a_n856_n321#
X0 a_n1750_n1013# a_n1750_n1013# a_n1750_n1013# a_n1750_n1013# nfet_03v3 ad=2.28p pd=6.28u as=18.24p ps=50.24u w=2u l=0.28u M=4
X1 a_n856_n321# a_n628_n849# a_n572_n321# a_n1750_n1013# nfet_03v3 ad=1.22p pd=3.22u as=1.22p ps=3.22u w=2u l=0.28u M=5
X2 a_3440_n321# a_3384_n849# a_3156_n321# a_n1750_n1013# nfet_03v3 ad=1.22p pd=3.22u as=2.28p ps=6.28u w=2u l=0.28u M=5
.ends

.subckt Gilbert_mixer_interdigited RF_diff_pair$1_0/a_n856_n321# RF_diff_pair$1_0/a_3384_n849#
+ RF_diff_pair$1_0/a_n628_n849# via_array_286f19cb$1_0/m2_n420_n210# via_array_6f2c13fe$2$2_0/m2_600_n100#
+ via_array_286f19cb_0/m2_n420_n210# via_array_6f2c13fe$3$2_0/m2_600_n100# RF_diff_pair$1_0/a_3440_n321#
+ VSUBS
XLO_diff_pairs_interdigitized_0 RF_diff_pair$1_0/a_3156_n321# via_array_286f19cb_0/m2_n420_n210#
+ via_array_286f19cb$1_0/m2_n420_n210# RF_diff_pair$1_0/a_n572_n321# via_array_6f2c13fe$2$2_0/m2_600_n100#
+ via_array_6f2c13fe$3$2_0/m2_600_n100# VSUBS LO_diff_pairs_interdigitized
XRF_diff_pair$1_0 RF_diff_pair$1_0/a_3384_n849# RF_diff_pair$1_0/a_3440_n321# RF_diff_pair$1_0/a_3156_n321#
+ RF_diff_pair$1_0/a_n628_n849# RF_diff_pair$1_0/a_n572_n321# VSUBS RF_diff_pair$1_0/a_n856_n321#
+ RF_diff_pair$1
.ends

.subckt Gilbert_mixer_layout V_LO V_LO_b V_RF V_RF_b V_IF_out VSS
XGilbert_mixer_loading_stage_0 V_IF_out V_IF_out VSS Gilbert_mixer_loading_stage
XBiasing_Network_0 m3_447543_98113# V_IF_out VSS V_IF_out m3_470429_92059# m3_504377_69961#
+ m3_470429_92059# m3_447543_98113# VSS Biasing_Network
XGilbert_mixer_interdigited_0 m3_447543_98113# V_LO_b V_RF V_RF_b V_IF_out V_LO V_IF_out
+ m3_447543_98113# VSS Gilbert_mixer_interdigited
.ends
