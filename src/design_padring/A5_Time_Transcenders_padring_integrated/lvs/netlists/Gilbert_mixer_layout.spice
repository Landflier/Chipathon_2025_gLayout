* NGSPICE file created from Gilbert_mixer_layout.ext - technology: gf180mcuD

.subckt ppolyf_u_95K9DY a_n100_n502# w_n316_n718# a_n100_400#
X0 a_n100_400# a_n100_n502# w_n316_n718# ppolyf_u r_width=1u r_length=4u
.ends

.subckt Degeneration_resistor m1_n54_n2403# m1_1068_147# m1_134_147#
Xppolyf_u_95K9DY_0 m1_134_147# m1_n54_n2403# m1_1068_147# ppolyf_u_95K9DY
.ends

.subckt ppolyf_u_high_Rs_resistor$1 a_4000_0# a_n128_0# w_n476_n268# a_4000_600# dw_n476_n268#
+ a_n128_600#
X0 a_n128_600# a_4000_600# w_n476_n268# ppolyf_u_1k r_width=1u r_length=20u
X1 a_n128_0# a_4000_0# w_n476_n268# ppolyf_u_1k r_width=1u r_length=20u
.ends

.subckt pfet_03v3_RFU83T a_181_n6# a_n125_n6# a_33_n12# w_n435_n238# a_n190_n119#
+ a_n273_n12#
X0 a_181_n6# a_n190_n119# a_33_n12# w_n435_n238# pfet_03v3 ad=0.1596p pd=1.64u as=0.1596p ps=1.64u w=0.3u l=0.28u
X1 a_n125_n6# a_n190_n119# a_n273_n12# w_n435_n238# pfet_03v3 ad=0.1596p pd=1.64u as=0.1596p ps=1.64u w=0.3u l=0.28u
.ends

.subckt nfet_03v3_AZGML9 a_n52_n50# a_n276_70# a_n212_n50# a_n356_n36# a_n116_n142#
+ a_n496_n388#
X0 a_n212_n50# a_n116_n142# a_n52_n50# a_n496_n388# nfet_03v3 ad=0.13p pd=1.02u as=0.13p ps=1.02u w=0.5u l=0.28u
X1 a_n356_n36# a_n276_70# a_n212_n50# a_n496_n388# nfet_03v3 ad=0.2109p pd=1.88u as=0.13p ps=1.02u w=0.5u l=0.28u
X2 a_n52_n50# a_n116_n142# a_n212_n50# a_n496_n388# nfet_03v3 ad=0.13p pd=1.02u as=0.13p ps=1.02u w=0.5u l=0.28u
X3 a_n212_n50# a_n276_70# a_n356_n36# a_n496_n388# nfet_03v3 ad=0.13p pd=1.02u as=0.2109p ps=1.88u w=0.5u l=0.28u
.ends

.subckt x4t-ota w_1372_318# m2_n392_n381# m2_1984_n621# m2_n420_n206# m1_1910_520#
+ VSUBS
Xpfet_03v3_RFU83T_0 m1_1910_520# w_1372_318# w_1372_318# w_1372_318# m1_1452_455#
+ m1_1452_455# pfet_03v3_RFU83T
Xnfet_03v3_AZGML9_0 m1_1910_520# m2_n392_n381# m2_1984_n621# m1_1452_455# m2_n420_n206#
+ VSUBS nfet_03v3_AZGML9
.ends

.subckt ppolyf_u_9H3LNU a_n4000_1000# a_n4000_n1102# w_n4216_n1318#
X0 a_n4000_1000# a_n4000_n1102# w_n4216_n1318# ppolyf_u r_width=40u r_length=10u
.ends

.subckt diode_nd2ps_06v0_MV3SZ3 a_116_n1000# a_2348_n1000# a_n4348_n1000# a_n4500_n1152#
+ a_n2116_n1000#
D0 a_n4500_n1152# a_116_n1000# diode_nd2ps_06v0 pj=40u area=99.99999p
D1 a_n4500_n1152# a_2348_n1000# diode_nd2ps_06v0 pj=40u area=99.99999p
D2 a_n4500_n1152# a_n4348_n1000# diode_nd2ps_06v0 pj=40u area=99.99999p
D3 a_n4500_n1152# a_n2116_n1000# diode_nd2ps_06v0 pj=40u area=99.99999p
.ends

.subckt diode_pd2nw_06v0_5DG9HC a_n2108_n1000# a_2324_n1000# w_n4500_n1176# a_n4324_n1000#
+ a_108_n1000#
D0 a_2324_n1000# w_n4500_n1176# diode_pd2nw_06v0 pj=40u area=99.99999p
D1 a_n4324_n1000# w_n4500_n1176# diode_pd2nw_06v0 pj=40u area=99.99999p
D2 a_n2108_n1000# w_n4500_n1176# diode_pd2nw_06v0 pj=40u area=99.99999p
D3 a_108_n1000# w_n4500_n1176# diode_pd2nw_06v0 pj=40u area=99.99999p
.ends

.subckt io_secondary_5p0 m1_6880_n1240# m1_n5943_7732# m1_n6440_11450# VSUBS
Xppolyf_u_9H3LNU_0 m1_6880_n1240# m1_n5943_7732# m1_n6440_11450# ppolyf_u_9H3LNU
Xdiode_nd2ps_06v0_MV3SZ3_0 m1_n5943_7732# m1_n5943_7732# m1_n5943_7732# VSUBS m1_n5943_7732#
+ diode_nd2ps_06v0_MV3SZ3
Xdiode_pd2nw_06v0_5DG9HC_0 m1_n5943_7732# m1_n5943_7732# m1_n6440_11450# m1_n5943_7732#
+ m1_n5943_7732# diode_pd2nw_06v0_5DG9HC
.ends

.subckt io_secondary_5p0_array io_secondary_5p0_1/m1_6880_n1240# io_secondary_5p0_4/m1_n6440_11450#
+ io_secondary_5p0_3/m1_n6440_11450# io_secondary_5p0_2/m1_6880_n1240# io_secondary_5p0_3/m1_n5943_7732#
+ io_secondary_5p0_2/m1_n6440_11450# io_secondary_5p0_0/m1_n5943_7732# io_secondary_5p0_4/m1_n5943_7732#
+ io_secondary_5p0_3/m1_6880_n1240# io_secondary_5p0_1/m1_n6440_11450# io_secondary_5p0_1/m1_n5943_7732#
+ io_secondary_5p0_0/m1_6880_n1240# io_secondary_5p0_0/m1_n6440_11450# io_secondary_5p0_4/m1_6880_n1240#
+ VSUBS io_secondary_5p0_2/m1_n5943_7732#
Xio_secondary_5p0_0 io_secondary_5p0_0/m1_6880_n1240# io_secondary_5p0_0/m1_n5943_7732#
+ io_secondary_5p0_0/m1_n6440_11450# VSUBS io_secondary_5p0
Xio_secondary_5p0_1 io_secondary_5p0_1/m1_6880_n1240# io_secondary_5p0_1/m1_n5943_7732#
+ io_secondary_5p0_1/m1_n6440_11450# VSUBS io_secondary_5p0
Xio_secondary_5p0_2 io_secondary_5p0_2/m1_6880_n1240# io_secondary_5p0_2/m1_n5943_7732#
+ io_secondary_5p0_2/m1_n6440_11450# VSUBS io_secondary_5p0
Xio_secondary_5p0_3 io_secondary_5p0_3/m1_6880_n1240# io_secondary_5p0_3/m1_n5943_7732#
+ io_secondary_5p0_3/m1_n6440_11450# VSUBS io_secondary_5p0
Xio_secondary_5p0_4 io_secondary_5p0_4/m1_6880_n1240# io_secondary_5p0_4/m1_n5943_7732#
+ io_secondary_5p0_4/m1_n6440_11450# VSUBS io_secondary_5p0
.ends

.subckt Unnamed_5b1479df m4_n620_n620# m4_n500_n500#
X0 m4_n500_n500# m4_n620_n620# cap_mim_2f0_m4m5_noshield c_width=5u c_length=5u
.ends

.subckt cmirror_interdigitized$4 a_n3932_n75# a_n4280_n495# a_n4540_n809#
X0 a_n4540_n809# a_n4280_n495# a_n3932_n75# a_n4540_n809# nfet_03v3 ad=0.345p pd=1.67u as=0.345p ps=1.67u w=0.75u l=1u
X1 a_n4540_n809# a_n4280_n495# a_n3932_n75# a_n4540_n809# nfet_03v3 ad=0.345p pd=1.67u as=0.345p ps=1.67u w=0.75u l=1u
X2 a_n3932_n75# a_n4280_n495# a_n4540_n809# a_n4540_n809# nfet_03v3 ad=0.345p pd=1.67u as=0.345p ps=1.67u w=0.75u l=1u
X3 a_n3932_n75# a_n4280_n495# a_n4540_n809# a_n4540_n809# nfet_03v3 ad=0.345p pd=1.67u as=0.345p ps=1.67u w=0.75u l=1u
X4 a_n4540_n809# a_n4280_n495# a_n3932_n75# a_n4540_n809# nfet_03v3 ad=0.345p pd=1.67u as=0.345p ps=1.67u w=0.75u l=1u
X5 a_n4540_n809# a_n4280_n495# a_n3932_n75# a_n4540_n809# nfet_03v3 ad=0.345p pd=1.67u as=0.345p ps=1.67u w=0.75u l=1u
X6 a_n3932_n75# a_n4280_n495# a_n4540_n809# a_n4540_n809# nfet_03v3 ad=0.345p pd=1.67u as=0.345p ps=1.67u w=0.75u l=1u
X7 a_n3932_n75# a_n4280_n495# a_n4540_n809# a_n4540_n809# nfet_03v3 ad=0.345p pd=1.67u as=0.345p ps=1.67u w=0.75u l=1u
X8 a_n4280_n495# a_n4280_n495# a_n4540_n809# a_n4540_n809# nfet_03v3 ad=0.345p pd=1.67u as=0.345p ps=1.67u w=0.75u l=1u
X9 a_n3932_n75# a_n4280_n495# a_n4540_n809# a_n4540_n809# nfet_03v3 ad=0.345p pd=1.67u as=0.7425p ps=3.48u w=0.75u l=1u
X10 a_n4540_n809# a_n4280_n495# a_n3932_n75# a_n4540_n809# nfet_03v3 ad=0.345p pd=1.67u as=0.345p ps=1.67u w=0.75u l=1u
X11 a_n4540_n809# a_n4280_n495# a_n4280_n495# a_n4540_n809# nfet_03v3 ad=0.345p pd=1.67u as=0.345p ps=1.67u w=0.75u l=1u
X12 a_n4540_n809# a_n4280_n495# a_n3932_n75# a_n4540_n809# nfet_03v3 ad=0.345p pd=1.67u as=0.345p ps=1.67u w=0.75u l=1u
X13 a_n3932_n75# a_n4280_n495# a_n4540_n809# a_n4540_n809# nfet_03v3 ad=0.345p pd=1.67u as=0.345p ps=1.67u w=0.75u l=1u
X14 a_n4540_n809# a_n4280_n495# a_n3932_n75# a_n4540_n809# nfet_03v3 ad=0.7425p pd=3.48u as=0.345p ps=1.67u w=0.75u l=1u
X15 a_n3932_n75# a_n4280_n495# a_n4540_n809# a_n4540_n809# nfet_03v3 ad=0.345p pd=1.67u as=0.345p ps=1.67u w=0.75u l=1u
X16 a_n4540_n809# a_n4280_n495# a_n3932_n75# a_n4540_n809# nfet_03v3 ad=0.345p pd=1.67u as=0.345p ps=1.67u w=0.75u l=1u
X17 a_n4540_n809# a_n4280_n495# a_n3932_n75# a_n4540_n809# nfet_03v3 ad=0.345p pd=1.67u as=0.345p ps=1.67u w=0.75u l=1u
X18 a_n3932_n75# a_n4280_n495# a_n4540_n809# a_n4540_n809# nfet_03v3 ad=0.345p pd=1.67u as=0.345p ps=1.67u w=0.75u l=1u
X19 a_n3932_n75# a_n4280_n495# a_n4540_n809# a_n4540_n809# nfet_03v3 ad=0.345p pd=1.67u as=0.345p ps=1.67u w=0.75u l=1u
X20 a_n4540_n809# a_n4280_n495# a_n3932_n75# a_n4540_n809# nfet_03v3 ad=0.345p pd=1.67u as=0.345p ps=1.67u w=0.75u l=1u
X21 a_n3932_n75# a_n4280_n495# a_n4540_n809# a_n4540_n809# nfet_03v3 ad=0.345p pd=1.67u as=0.345p ps=1.67u w=0.75u l=1u
.ends

.subckt nmos4_Cmirror_with_decap$1 via_array_6f2c13fe$7_0/m2_n100_n100# Unnamed_5b1479df_0/m4_n620_n620#
+ VSUBS
XUnnamed_5b1479df_0 Unnamed_5b1479df_0/m4_n620_n620# VSUBS Unnamed_5b1479df
Xcmirror_interdigitized$4_0 via_array_6f2c13fe$7_0/m2_n100_n100# Unnamed_5b1479df_0/m4_n620_n620#
+ VSUBS cmirror_interdigitized$4
.ends

.subckt cmirror_interdigitized$2$1 a_n2410_n75# a_n2360_n495# a_n2620_n809#
X0 a_n2620_n809# a_n2360_n495# a_n2410_n75# a_n2620_n809# nfet_03v3 ad=0.345p pd=1.67u as=0.345p ps=1.67u w=0.75u l=1u
X1 a_n2620_n809# a_n2360_n495# a_n2410_n75# a_n2620_n809# nfet_03v3 ad=0.345p pd=1.67u as=0.7425p ps=3.48u w=0.75u l=1u
X2 a_n2410_n75# a_n2360_n495# a_n2620_n809# a_n2620_n809# nfet_03v3 ad=0.345p pd=1.67u as=0.345p ps=1.67u w=0.75u l=1u
X3 a_n2410_n75# a_n2360_n495# a_n2620_n809# a_n2620_n809# nfet_03v3 ad=0.345p pd=1.67u as=0.345p ps=1.67u w=0.75u l=1u
X4 a_n2620_n809# a_n2360_n495# a_n2410_n75# a_n2620_n809# nfet_03v3 ad=0.345p pd=1.67u as=0.345p ps=1.67u w=0.75u l=1u
X5 a_n2620_n809# a_n2360_n495# a_n2410_n75# a_n2620_n809# nfet_03v3 ad=0.345p pd=1.67u as=0.345p ps=1.67u w=0.75u l=1u
X6 a_n2410_n75# a_n2360_n495# a_n2620_n809# a_n2620_n809# nfet_03v3 ad=0.345p pd=1.67u as=0.345p ps=1.67u w=0.75u l=1u
X7 a_n2410_n75# a_n2360_n495# a_n2620_n809# a_n2620_n809# nfet_03v3 ad=0.345p pd=1.67u as=0.345p ps=1.67u w=0.75u l=1u
X8 a_n2360_n495# a_n2360_n495# a_n2620_n809# a_n2620_n809# nfet_03v3 ad=0.345p pd=1.67u as=0.345p ps=1.67u w=0.75u l=1u
X9 a_n2620_n809# a_n2360_n495# a_n2410_n75# a_n2620_n809# nfet_03v3 ad=0.345p pd=1.67u as=0.345p ps=1.67u w=0.75u l=1u
X10 a_n2620_n809# a_n2360_n495# a_n2360_n495# a_n2620_n809# nfet_03v3 ad=0.345p pd=1.67u as=0.345p ps=1.67u w=0.75u l=1u
X11 a_n2410_n75# a_n2360_n495# a_n2620_n809# a_n2620_n809# nfet_03v3 ad=0.7425p pd=3.48u as=0.345p ps=1.67u w=0.75u l=1u
.ends

.subckt Unnamed_e1f3752b$1$1 m4_n620_n620# m4_n500_n500#
X0 m4_n500_n500# m4_n620_n620# cap_mim_2f0_m4m5_noshield c_width=5u c_length=5u
.ends

.subckt nmos2_Cmirror_with_decap via_array_6f2c13fe$3$3_0/m2_n100_n100# Unnamed_e1f3752b$1$1_0/m4_n620_n620#
+ VSUBS
Xcmirror_interdigitized$2$1_0 via_array_6f2c13fe$3$3_0/m2_n100_n100# Unnamed_e1f3752b$1$1_0/m4_n620_n620#
+ VSUBS cmirror_interdigitized$2$1
XUnnamed_e1f3752b$1$1_0 Unnamed_e1f3752b$1$1_0/m4_n620_n620# VSUBS Unnamed_e1f3752b$1$1
.ends

.subckt Unnamed_df7b41fc$1$1 m4_n620_n620# m4_n500_n500#
X0 m4_n500_n500# m4_n620_n620# cap_mim_2f0_m4m5_noshield c_width=5u c_length=5u
.ends

.subckt cmirror_interdigitized$5 a_n1412_n50# w_n2485_n1240# a_n2168_n570#
X0 a_n1412_n50# a_n2168_n570# w_n2485_n1240# w_n2485_n1240# pfet_03v3 ad=0.23p pd=1.42u as=0.23p ps=1.42u w=0.5u l=0.4u
X1 w_n2485_n1240# a_n2168_n570# a_n2168_n570# w_n2485_n1240# pfet_03v3 ad=0.495p pd=2.98u as=0.23p ps=1.42u w=0.5u l=0.4u
X2 a_n1412_n50# a_n2168_n570# w_n2485_n1240# w_n2485_n1240# pfet_03v3 ad=0.23p pd=1.42u as=0.23p ps=1.42u w=0.5u l=0.4u
X3 w_n2485_n1240# a_n2168_n570# a_n2168_n570# w_n2485_n1240# pfet_03v3 ad=0.23p pd=1.42u as=0.23p ps=1.42u w=0.5u l=0.4u
X4 w_n2485_n1240# a_n2168_n570# a_n1412_n50# w_n2485_n1240# pfet_03v3 ad=0.23p pd=1.42u as=0.23p ps=1.42u w=0.5u l=0.4u
X5 a_n2168_n570# a_n2168_n570# w_n2485_n1240# w_n2485_n1240# pfet_03v3 ad=0.23p pd=1.42u as=0.23p ps=1.42u w=0.5u l=0.4u
X6 a_n1412_n50# a_n2168_n570# w_n2485_n1240# w_n2485_n1240# pfet_03v3 ad=0.23p pd=1.42u as=0.23p ps=1.42u w=0.5u l=0.4u
X7 a_n1412_n50# a_n2168_n570# w_n2485_n1240# w_n2485_n1240# pfet_03v3 ad=0.23p pd=1.42u as=0.23p ps=1.42u w=0.5u l=0.4u
X8 w_n2485_n1240# a_n2168_n570# a_n1412_n50# w_n2485_n1240# pfet_03v3 ad=0.23p pd=1.42u as=0.23p ps=1.42u w=0.5u l=0.4u
X9 a_n1412_n50# a_n2168_n570# w_n2485_n1240# w_n2485_n1240# pfet_03v3 ad=0.23p pd=1.42u as=0.23p ps=1.42u w=0.5u l=0.4u
X10 w_n2485_n1240# a_n2168_n570# a_n1412_n50# w_n2485_n1240# pfet_03v3 ad=0.23p pd=1.42u as=0.23p ps=1.42u w=0.5u l=0.4u
X11 a_n2168_n570# a_n2168_n570# w_n2485_n1240# w_n2485_n1240# pfet_03v3 ad=0.23p pd=1.42u as=0.495p ps=2.98u w=0.5u l=0.4u
X12 w_n2485_n1240# a_n2168_n570# a_n1412_n50# w_n2485_n1240# pfet_03v3 ad=0.23p pd=1.42u as=0.23p ps=1.42u w=0.5u l=0.4u
X13 w_n2485_n1240# a_n2168_n570# a_n1412_n50# w_n2485_n1240# pfet_03v3 ad=0.23p pd=1.42u as=0.23p ps=1.42u w=0.5u l=0.4u
X14 a_n1412_n50# a_n2168_n570# w_n2485_n1240# w_n2485_n1240# pfet_03v3 ad=0.23p pd=1.42u as=0.23p ps=1.42u w=0.5u l=0.4u
X15 w_n2485_n1240# a_n2168_n570# a_n1412_n50# w_n2485_n1240# pfet_03v3 ad=0.23p pd=1.42u as=0.23p ps=1.42u w=0.5u l=0.4u
.ends

.subckt pmos_Cmirror_with_decap Unnamed_df7b41fc$1$1_0/m4_n500_n500# Unnamed_df7b41fc$1$1_0/m4_n620_n620#
+ cmirror_interdigitized$5_0/a_n1412_n50#
XUnnamed_df7b41fc$1$1_0 Unnamed_df7b41fc$1$1_0/m4_n620_n620# Unnamed_df7b41fc$1$1_0/m4_n500_n500#
+ Unnamed_df7b41fc$1$1
Xcmirror_interdigitized$5_0 cmirror_interdigitized$5_0/a_n1412_n50# Unnamed_df7b41fc$1$1_0/m4_n500_n500#
+ Unnamed_df7b41fc$1$1_0/m4_n620_n620# cmirror_interdigitized$5
.ends

.subckt Unnamed_3026f522$1$1 m4_n620_n620# m4_n500_n500#
X0 m4_n500_n500# m4_n620_n620# cap_mim_2f0_m4m5_noshield c_width=5u c_length=5u
.ends

.subckt cmirror_interdigitized$1$1 a_n2410_n75# a_n2360_n495# a_n2620_n809#
X0 a_n2620_n809# a_n2360_n495# a_n2410_n75# a_n2620_n809# nfet_03v3 ad=0.345p pd=1.67u as=0.345p ps=1.67u w=0.75u l=1u
X1 a_n2620_n809# a_n2360_n495# a_n2410_n75# a_n2620_n809# nfet_03v3 ad=0.345p pd=1.67u as=0.7425p ps=3.48u w=0.75u l=1u
X2 a_n2410_n75# a_n2360_n495# a_n2620_n809# a_n2620_n809# nfet_03v3 ad=0.345p pd=1.67u as=0.345p ps=1.67u w=0.75u l=1u
X3 a_n2410_n75# a_n2360_n495# a_n2620_n809# a_n2620_n809# nfet_03v3 ad=0.345p pd=1.67u as=0.345p ps=1.67u w=0.75u l=1u
X4 a_n2620_n809# a_n2360_n495# a_n2410_n75# a_n2620_n809# nfet_03v3 ad=0.345p pd=1.67u as=0.345p ps=1.67u w=0.75u l=1u
X5 a_n2620_n809# a_n2360_n495# a_n2410_n75# a_n2620_n809# nfet_03v3 ad=0.345p pd=1.67u as=0.345p ps=1.67u w=0.75u l=1u
X6 a_n2410_n75# a_n2360_n495# a_n2620_n809# a_n2620_n809# nfet_03v3 ad=0.345p pd=1.67u as=0.345p ps=1.67u w=0.75u l=1u
X7 a_n2410_n75# a_n2360_n495# a_n2620_n809# a_n2620_n809# nfet_03v3 ad=0.345p pd=1.67u as=0.345p ps=1.67u w=0.75u l=1u
X8 a_n2360_n495# a_n2360_n495# a_n2620_n809# a_n2620_n809# nfet_03v3 ad=0.345p pd=1.67u as=0.345p ps=1.67u w=0.75u l=1u
X9 a_n2620_n809# a_n2360_n495# a_n2410_n75# a_n2620_n809# nfet_03v3 ad=0.345p pd=1.67u as=0.345p ps=1.67u w=0.75u l=1u
X10 a_n2620_n809# a_n2360_n495# a_n2360_n495# a_n2620_n809# nfet_03v3 ad=0.345p pd=1.67u as=0.345p ps=1.67u w=0.75u l=1u
X11 a_n2410_n75# a_n2360_n495# a_n2620_n809# a_n2620_n809# nfet_03v3 ad=0.7425p pd=3.48u as=0.345p ps=1.67u w=0.75u l=1u
.ends

.subckt nmos1_Cmirror_with_decap L_route_9825ad4f$2_0/m2_n4400_n435# via_array_6f2c13fe$1$2$1_0/m2_n100_n100#
+ VSUBS
XUnnamed_3026f522$1$1_0 L_route_9825ad4f$2_0/m2_n4400_n435# VSUBS Unnamed_3026f522$1$1
Xcmirror_interdigitized$1$1_0 via_array_6f2c13fe$1$2$1_0/m2_n100_n100# L_route_9825ad4f$2_0/m2_n4400_n435#
+ VSUBS cmirror_interdigitized$1$1
.ends

.subckt cmirror_interdigitized$3$1 a_n824_n495# a_n1084_n809# a_n874_n75#
X0 a_n874_n75# a_n824_n495# a_n1084_n809# a_n1084_n809# nfet_03v3 ad=0.7425p pd=3.48u as=0.345p ps=1.67u w=0.75u l=1u
X1 a_n824_n495# a_n824_n495# a_n1084_n809# a_n1084_n809# nfet_03v3 ad=0.345p pd=1.67u as=0.345p ps=1.67u w=0.75u l=1u
X2 a_n1084_n809# a_n824_n495# a_n874_n75# a_n1084_n809# nfet_03v3 ad=0.345p pd=1.67u as=0.7425p ps=3.48u w=0.75u l=1u
X3 a_n1084_n809# a_n824_n495# a_n824_n495# a_n1084_n809# nfet_03v3 ad=0.345p pd=1.67u as=0.345p ps=1.67u w=0.75u l=1u
.ends

.subckt Unnamed_34e3354a$1$1 m4_n620_n620# m4_n500_n500#
X0 m4_n500_n500# m4_n620_n620# cap_mim_2f0_m4m5_noshield c_width=5u c_length=5u
.ends

.subckt nmos3_Cmirror_with_decap via_array_6f2c13fe$5$1_0/m2_n100_n100# L_route_b498a5d1$1_0/m2_n5562_n435#
+ VSUBS
Xcmirror_interdigitized$3$1_0 L_route_b498a5d1$1_0/m2_n5562_n435# VSUBS via_array_6f2c13fe$5$1_0/m2_n100_n100#
+ cmirror_interdigitized$3$1
XUnnamed_34e3354a$1$1_0 L_route_b498a5d1$1_0/m2_n5562_n435# VSUBS Unnamed_34e3354a$1$1
.ends

.subckt Biasing_network_with_local_mirror nmos3_Cmirror_with_decap_0/via_array_6f2c13fe$5$1_0/m2_n100_n100#
+ nmos4_Cmirror_with_decap$1_0/Unnamed_5b1479df_0/m4_n620_n620# nmos2_Cmirror_with_decap_0/Unnamed_e1f3752b$1$1_0/m4_n620_n620#
+ pmos_Cmirror_with_decap_0/Unnamed_df7b41fc$1$1_0/m4_n500_n500# nmos2_Cmirror_with_decap_0/via_array_6f2c13fe$3$3_0/m2_n100_n100#
+ nmos1_Cmirror_with_decap_0/L_route_9825ad4f$2_0/m2_n4400_n435# nmos3_Cmirror_with_decap_0/L_route_b498a5d1$1_0/m2_n5562_n435#
+ nmos1_Cmirror_with_decap_0/via_array_6f2c13fe$1$2$1_0/m2_n100_n100# nmos4_Cmirror_with_decap$1_0/via_array_6f2c13fe$7_0/m2_n100_n100#
+ pmos_Cmirror_with_decap_0/cmirror_interdigitized$5_0/a_n1412_n50# pmos_Cmirror_with_decap_0/Unnamed_df7b41fc$1$1_0/m4_n620_n620#
+ VSUBS
Xnmos4_Cmirror_with_decap$1_0 nmos4_Cmirror_with_decap$1_0/via_array_6f2c13fe$7_0/m2_n100_n100#
+ nmos4_Cmirror_with_decap$1_0/Unnamed_5b1479df_0/m4_n620_n620# VSUBS nmos4_Cmirror_with_decap$1
Xnmos2_Cmirror_with_decap_0 nmos2_Cmirror_with_decap_0/via_array_6f2c13fe$3$3_0/m2_n100_n100#
+ nmos2_Cmirror_with_decap_0/Unnamed_e1f3752b$1$1_0/m4_n620_n620# VSUBS nmos2_Cmirror_with_decap
Xpmos_Cmirror_with_decap_0 pmos_Cmirror_with_decap_0/Unnamed_df7b41fc$1$1_0/m4_n500_n500#
+ pmos_Cmirror_with_decap_0/Unnamed_df7b41fc$1$1_0/m4_n620_n620# pmos_Cmirror_with_decap_0/cmirror_interdigitized$5_0/a_n1412_n50#
+ pmos_Cmirror_with_decap
Xnmos1_Cmirror_with_decap_0 nmos1_Cmirror_with_decap_0/L_route_9825ad4f$2_0/m2_n4400_n435#
+ nmos1_Cmirror_with_decap_0/via_array_6f2c13fe$1$2$1_0/m2_n100_n100# VSUBS nmos1_Cmirror_with_decap
Xnmos3_Cmirror_with_decap_0 nmos3_Cmirror_with_decap_0/via_array_6f2c13fe$5$1_0/m2_n100_n100#
+ nmos3_Cmirror_with_decap_0/L_route_b498a5d1$1_0/m2_n5562_n435# VSUBS nmos3_Cmirror_with_decap
.ends

.subckt LO_diff_pairs_interdigitized a_n2222_n400# a_n2878_n1500# a_n2578_n448# a_n2822_n400#
+ a_n3106_n400# a_n2522_n400# a_n3316_n1664#
X0 a_n2522_n400# a_n2578_n448# a_n2822_n400# a_n3316_n1664# nfet_03v3 ad=2.44p pd=5.22u as=2.44p ps=5.22u w=4u l=0.28u
X1 a_n3106_n400# a_n2578_n448# a_n2222_n400# a_n3316_n1664# nfet_03v3 ad=2.44p pd=5.22u as=2.44p ps=5.22u w=4u l=0.28u
X2 a_n3106_n400# a_n2578_n448# a_n2222_n400# a_n3316_n1664# nfet_03v3 ad=2.44p pd=5.22u as=2.44p ps=5.22u w=4u l=0.28u
X3 a_n2822_n400# a_n2878_n1500# a_n3106_n400# a_n3316_n1664# nfet_03v3 ad=2.44p pd=5.22u as=2.44p ps=5.22u w=4u l=0.28u
X4 a_n2222_n400# a_n2878_n1500# a_n2522_n400# a_n3316_n1664# nfet_03v3 ad=2.44p pd=5.22u as=2.44p ps=5.22u w=4u l=0.28u
X5 a_n2222_n400# a_n2878_n1500# a_n2522_n400# a_n3316_n1664# nfet_03v3 ad=2.44p pd=5.22u as=2.44p ps=5.22u w=4u l=0.28u
X6 a_n2822_n400# a_n2878_n1500# a_n3106_n400# a_n3316_n1664# nfet_03v3 ad=2.44p pd=5.22u as=2.44p ps=5.22u w=4u l=0.28u
X7 a_n2822_n400# a_n2878_n1500# a_n3106_n400# a_n3316_n1664# nfet_03v3 ad=2.44p pd=5.22u as=2.44p ps=5.22u w=4u l=0.28u
X8 a_n2822_n400# a_n2878_n1500# a_n3106_n400# a_n3316_n1664# nfet_03v3 ad=2.44p pd=5.22u as=2.44p ps=5.22u w=4u l=0.28u
X9 a_n3106_n400# a_n2578_n448# a_n2222_n400# a_n3316_n1664# nfet_03v3 ad=2.44p pd=5.22u as=2.44p ps=5.22u w=4u l=0.28u
X10 a_n2522_n400# a_n2578_n448# a_n2822_n400# a_n3316_n1664# nfet_03v3 ad=2.44p pd=5.22u as=2.44p ps=5.22u w=4u l=0.28u
X11 a_n3106_n400# a_n2578_n448# a_n2222_n400# a_n3316_n1664# nfet_03v3 ad=4.56p pd=10.28u as=2.44p ps=5.22u w=4u l=0.28u
X12 a_n2522_n400# a_n2578_n448# a_n2822_n400# a_n3316_n1664# nfet_03v3 ad=2.44p pd=5.22u as=2.44p ps=5.22u w=4u l=0.28u
X13 a_n3106_n400# a_n2578_n448# a_n2222_n400# a_n3316_n1664# nfet_03v3 ad=2.44p pd=5.22u as=2.44p ps=5.22u w=4u l=0.28u
X14 a_n2822_n400# a_n2878_n1500# a_n3106_n400# a_n3316_n1664# nfet_03v3 ad=2.44p pd=5.22u as=4.56p ps=10.28u w=4u l=0.28u
X15 a_n2222_n400# a_n2878_n1500# a_n2522_n400# a_n3316_n1664# nfet_03v3 ad=2.44p pd=5.22u as=2.44p ps=5.22u w=4u l=0.28u
X16 a_n2222_n400# a_n2878_n1500# a_n2522_n400# a_n3316_n1664# nfet_03v3 ad=2.44p pd=5.22u as=2.44p ps=5.22u w=4u l=0.28u
X17 a_n2222_n400# a_n2878_n1500# a_n2522_n400# a_n3316_n1664# nfet_03v3 ad=2.44p pd=5.22u as=2.44p ps=5.22u w=4u l=0.28u
X18 a_n2522_n400# a_n2578_n448# a_n2822_n400# a_n3316_n1664# nfet_03v3 ad=2.44p pd=5.22u as=2.44p ps=5.22u w=4u l=0.28u
X19 a_n2522_n400# a_n2578_n448# a_n2822_n400# a_n3316_n1664# nfet_03v3 ad=2.44p pd=5.22u as=2.44p ps=5.22u w=4u l=0.28u
.ends

.subckt RF_diff_pair$1 a_3384_n849# a_3440_n321# a_3156_n321# a_n628_n849# a_n572_n321#
+ a_n1750_n1013# a_n856_n321#
X0 a_n1750_n1013# a_n1750_n1013# a_n1750_n1013# a_n1750_n1013# nfet_03v3 ad=2.28p pd=6.28u as=18.24p ps=50.24u w=2u l=0.28u
X1 a_n856_n321# a_n628_n849# a_n572_n321# a_n1750_n1013# nfet_03v3 ad=1.22p pd=3.22u as=1.22p ps=3.22u w=2u l=0.28u
X2 a_n1750_n1013# a_n1750_n1013# a_n1750_n1013# a_n1750_n1013# nfet_03v3 ad=2.28p pd=6.28u as=0 ps=0 w=2u l=0.28u
X3 a_n572_n321# a_n628_n849# a_n856_n321# a_n1750_n1013# nfet_03v3 ad=1.22p pd=3.22u as=2.28p ps=6.28u w=2u l=0.28u
X4 a_n572_n321# a_n628_n849# a_n856_n321# a_n1750_n1013# nfet_03v3 ad=2.28p pd=6.28u as=1.22p ps=3.22u w=2u l=0.28u
X5 a_3440_n321# a_3384_n849# a_3156_n321# a_n1750_n1013# nfet_03v3 ad=1.22p pd=3.22u as=2.28p ps=6.28u w=2u l=0.28u
X6 a_n1750_n1013# a_n1750_n1013# a_n1750_n1013# a_n1750_n1013# nfet_03v3 ad=2.28p pd=6.28u as=0 ps=0 w=2u l=0.28u
X7 a_n572_n321# a_n628_n849# a_n856_n321# a_n1750_n1013# nfet_03v3 ad=1.22p pd=3.22u as=1.22p ps=3.22u w=2u l=0.28u
X8 a_3156_n321# a_3384_n849# a_3440_n321# a_n1750_n1013# nfet_03v3 ad=1.22p pd=3.22u as=1.22p ps=3.22u w=2u l=0.28u
X9 a_3156_n321# a_3384_n849# a_3440_n321# a_n1750_n1013# nfet_03v3 ad=1.22p pd=3.22u as=1.22p ps=3.22u w=2u l=0.28u
X10 a_3440_n321# a_3384_n849# a_3156_n321# a_n1750_n1013# nfet_03v3 ad=2.28p pd=6.28u as=1.22p ps=3.22u w=2u l=0.28u
X11 a_n1750_n1013# a_n1750_n1013# a_n1750_n1013# a_n1750_n1013# nfet_03v3 ad=2.28p pd=6.28u as=0 ps=0 w=2u l=0.28u
X12 a_3440_n321# a_3384_n849# a_3156_n321# a_n1750_n1013# nfet_03v3 ad=1.22p pd=3.22u as=1.22p ps=3.22u w=2u l=0.28u
X13 a_n856_n321# a_n628_n849# a_n572_n321# a_n1750_n1013# nfet_03v3 ad=1.22p pd=3.22u as=1.22p ps=3.22u w=2u l=0.28u
.ends

.subckt Gilbert_mixer_interdigited RF_diff_pair$1_0/a_3384_n849# RF_diff_pair$1_0/a_n628_n849#
+ via_array_286f19cb$1_0/m2_n420_n210# RF_diff_pair$1_0/a_n856_n321# via_array_286f19cb_0/m2_n420_n210#
+ straight_route_508b4dcb$1_0/m2_3050_770# straight_route_eaf86bfa$1_0/m2_3050_510#
+ RF_diff_pair$1_0/a_3440_n321# VSUBS
XLO_diff_pairs_interdigitized_0 RF_diff_pair$1_0/a_3156_n321# via_array_286f19cb_0/m2_n420_n210#
+ via_array_286f19cb$1_0/m2_n420_n210# RF_diff_pair$1_0/a_n572_n321# straight_route_eaf86bfa$1_0/m2_3050_510#
+ straight_route_508b4dcb$1_0/m2_3050_770# VSUBS LO_diff_pairs_interdigitized
XRF_diff_pair$1_0 RF_diff_pair$1_0/a_3384_n849# RF_diff_pair$1_0/a_3440_n321# RF_diff_pair$1_0/a_3156_n321#
+ RF_diff_pair$1_0/a_n628_n849# RF_diff_pair$1_0/a_n572_n321# VSUBS RF_diff_pair$1_0/a_n856_n321#
+ RF_diff_pair$1
.ends

.subckt Gilbert_mixer_layout VSS VDD I_bias V_LO_b V_RF_b V_IF_out V_LO V_RF
XDegeneration_resistor_0 VDD m3_447543_97161# m3_436631_97159# Degeneration_resistor
Xppolyf_u_high_Rs_resistor$1_0 m3_448977_101781# VDD VSS m3_448551_101181# VSS VDD
+ ppolyf_u_high_Rs_resistor$1
X4t-ota_0 VDD m3_448551_101181# m3_454799_105309# m3_448977_101781# V_IF_out VSS x4t-ota
Xio_secondary_5p0_array_0 V_LO VDD VDD V_RF m3_481277_78532# VDD m3_459617_77034#
+ m3_502897_84306# V_LO_b VDD m3_402897_80642# V_RF_b VDD I_bias VSS m3_424557_78204#
+ io_secondary_5p0_array
XBiasing_network_with_local_mirror_0 m3_454799_105309# m3_477022_91134# m3_477022_91134#
+ VDD m3_447543_97161# m3_477022_91134# m3_477022_91134# m3_436631_97159# V_IF_out
+ m3_477022_91134# m3_502897_84306# VSS Biasing_network_with_local_mirror
XGilbert_mixer_interdigited_0 m3_459617_77034# m3_424557_78204# m3_481277_78532# m3_436631_97159#
+ m3_402897_80642# m3_448977_101781# m3_448551_101181# m3_447543_97161# VSS Gilbert_mixer_interdigited
.ends
