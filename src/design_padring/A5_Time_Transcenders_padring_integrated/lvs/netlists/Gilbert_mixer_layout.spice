* NGSPICE file created from Gilbert_mixer_layout.ext - technology: gf180mcuD

.subckt nfet_03v3_N8FQLR a_n372_n200# a_n436_n292# a_n116_220# m1_n655_n892# a_n516_n163#
+ a_n655_n527#
X0 a_n372_n200# a_n436_n292# a_n516_n163# a_n655_n527# nfet_03v3 ad=0.52p pd=2.52u as=0.85595p ps=4.88u w=2u l=0.28u M=4
X1 a_n516_n163# a_n116_220# a_n436_n292# a_n655_n527# nfet_03v3 ad=0.52p pd=2.52u as=0.52p ps=2.52u w=2u l=0.28u M=2
.ends

.subckt Output_stage m2_984_n286# nfet_03v3_N8FQLR_0/m1_n655_n892# m2_1009_459# m2_n361_338#
+ m2_451_n2630#
Xnfet_03v3_N8FQLR_0 m2_1009_459# m2_451_n2630# m2_n361_338# nfet_03v3_N8FQLR_0/m1_n655_n892#
+ m2_984_n286# m1_n158_415# nfet_03v3_N8FQLR
.ends

.subckt Degeneration_resistor w_n476_n164#
X0 a_n104_0# a_1000_0# w_n476_n164# pplus_u r_width=0.5u r_length=5u
.ends

.subckt ppolyf_u_1k_DB8C7L a_n520_n192# a_n240_1192# a_n732_n1526# a_n240_70# a_n520_1192#
+ a_n240_n1314# a_320_n1314# a_40_n192# a_320_n192# a_n520_70# a_n520_n1314# a_320_70#
+ a_n240_n192# a_40_70# a_40_1192# a_40_n1314# a_320_1192#
X0 a_n520_1192# a_n520_70# a_n732_n1526# ppolyf_u_1k r_width=1u r_length=5u
X1 a_n240_1192# a_n240_70# a_n732_n1526# ppolyf_u_1k r_width=1u r_length=5u
X2 a_40_1192# a_40_70# a_n732_n1526# ppolyf_u_1k r_width=1u r_length=5u
X3 a_320_n192# a_320_n1314# a_n732_n1526# ppolyf_u_1k r_width=1u r_length=5u
X4 a_320_1192# a_320_70# a_n732_n1526# ppolyf_u_1k r_width=1u r_length=5u
X5 a_n240_n192# a_n240_n1314# a_n732_n1526# ppolyf_u_1k r_width=1u r_length=5u
X6 a_40_n192# a_40_n1314# a_n732_n1526# ppolyf_u_1k r_width=1u r_length=5u
X7 a_n520_n192# a_n520_n1314# a_n732_n1526# ppolyf_u_1k r_width=1u r_length=5u
.ends

.subckt Gilbert_mixer_loading_stage m1_168_2735# m1_168_194# VSUBS
Xppolyf_u_1k_DB8C7L_0 m1_170_1346# m1_459_2748# VSUBS m1_170_1346# m1_168_2735# m1_459_192#
+ VSUBS m1_741_1366# m1_730_1578# m1_181_1461# m1_168_194# m1_741_1366# m1_181_1461#
+ m1_730_1578# m1_459_2748# m1_459_192# VSUBS ppolyf_u_1k_DB8C7L
.ends

.subckt pfet_03v3_RFU83T$1 a_181_n6# a_n125_n6# a_33_n12# w_n435_n238# a_n190_n119#
+ a_n273_n12#
X0 a_181_n6# a_n190_n119# a_33_n12# w_n435_n238# pfet_03v3 ad=0.1596p pd=1.64u as=0.1596p ps=1.64u w=0.3u l=0.28u
X1 a_n125_n6# a_n190_n119# a_n273_n12# w_n435_n238# pfet_03v3 ad=0.1596p pd=1.64u as=0.1596p ps=1.64u w=0.3u l=0.28u
.ends

.subckt nfet_03v3_AZGML9$1 a_n52_n50# a_n276_70# a_n212_n50# a_n356_n36# a_n116_n142#
+ a_n496_n388#
X0 a_n212_n50# a_n116_n142# a_n52_n50# a_n496_n388# nfet_03v3 ad=0.13p pd=1.02u as=0.13p ps=1.02u w=0.5u l=0.28u M=2
X1 a_n356_n36# a_n276_70# a_n212_n50# a_n496_n388# nfet_03v3 ad=0.2109p pd=1.88u as=0.13p ps=1.02u w=0.5u l=0.28u M=2
.ends

.subckt x4t-ota w_1372_318# m2_1984_n621# m2_939_n381# m2_939_n206# m1_1910_520# VSUBS
Xpfet_03v3_RFU83T_0 m1_1910_520# w_1372_318# w_1372_318# w_1372_318# m1_1452_455#
+ m1_1452_455# pfet_03v3_RFU83T$1
Xnfet_03v3_AZGML9_0 m1_1910_520# m2_939_n381# m2_1984_n621# m1_1452_455# m2_939_n206#
+ VSUBS nfet_03v3_AZGML9$1
.ends

.subckt ppolyf_u_9H3LNU a_n4000_1000# a_n4000_n1102# w_n4216_n1318#
X0 a_n4000_1000# a_n4000_n1102# w_n4216_n1318# ppolyf_u r_width=40u r_length=10u
.ends

.subckt diode_nd2ps_06v0_MV3SZ3 a_116_n1000# a_2348_n1000# a_n4348_n1000# a_n4500_n1152#
+ a_n2116_n1000#
D0 a_n4500_n1152# a_116_n1000# diode_nd2ps_06v0 pj=40u area=99.99999p
D1 a_n4500_n1152# a_2348_n1000# diode_nd2ps_06v0 pj=40u area=99.99999p
D2 a_n4500_n1152# a_n4348_n1000# diode_nd2ps_06v0 pj=40u area=99.99999p
D3 a_n4500_n1152# a_n2116_n1000# diode_nd2ps_06v0 pj=40u area=99.99999p
.ends

.subckt diode_pd2nw_06v0_5DG9HC a_n2108_n1000# a_2324_n1000# w_n4500_n1176# a_n4324_n1000#
+ a_108_n1000#
D0 a_2324_n1000# w_n4500_n1176# diode_pd2nw_06v0 pj=40u area=99.99999p
D1 a_n4324_n1000# w_n4500_n1176# diode_pd2nw_06v0 pj=40u area=99.99999p
D2 a_n2108_n1000# w_n4500_n1176# diode_pd2nw_06v0 pj=40u area=99.99999p
D3 a_108_n1000# w_n4500_n1176# diode_pd2nw_06v0 pj=40u area=99.99999p
.ends

.subckt io_secondary_5p0 m1_6880_n1240# m1_n5943_7732# m1_n6440_11450# VSUBS
Xppolyf_u_9H3LNU_0 m1_6880_n1240# m1_n5943_7732# m1_n6440_11450# ppolyf_u_9H3LNU
Xdiode_nd2ps_06v0_MV3SZ3_0 m1_n5943_7732# m1_n5943_7732# m1_n5943_7732# VSUBS m1_n5943_7732#
+ diode_nd2ps_06v0_MV3SZ3
Xdiode_pd2nw_06v0_5DG9HC_0 m1_n5943_7732# m1_n5943_7732# m1_n6440_11450# m1_n5943_7732#
+ m1_n5943_7732# diode_pd2nw_06v0_5DG9HC
.ends

.subckt io_secondary_5p0_under_hierarchy io_secondary_5p0_1/m1_6880_n1240# io_secondary_5p0_2/m1_6880_n1240#
+ io_secondary_5p0_3/m1_n5943_7732# io_secondary_5p0_0/m1_n5943_7732# io_secondary_5p0_4/m1_n5943_7732#
+ io_secondary_5p0_3/m1_6880_n1240# io_secondary_5p0_0/m1_6880_n1240# io_secondary_5p0_1/m1_n5943_7732#
+ m2_9867_1130# io_secondary_5p0_4/m1_6880_n1240# VSUBS io_secondary_5p0_2/m1_n5943_7732#
Xio_secondary_5p0_0 io_secondary_5p0_0/m1_6880_n1240# io_secondary_5p0_0/m1_n5943_7732#
+ m2_9867_1130# VSUBS io_secondary_5p0
Xio_secondary_5p0_1 io_secondary_5p0_1/m1_6880_n1240# io_secondary_5p0_1/m1_n5943_7732#
+ m2_9867_1130# VSUBS io_secondary_5p0
Xio_secondary_5p0_2 io_secondary_5p0_2/m1_6880_n1240# io_secondary_5p0_2/m1_n5943_7732#
+ m2_9867_1130# VSUBS io_secondary_5p0
Xio_secondary_5p0_3 io_secondary_5p0_3/m1_6880_n1240# io_secondary_5p0_3/m1_n5943_7732#
+ m2_9867_1130# VSUBS io_secondary_5p0
Xio_secondary_5p0_4 io_secondary_5p0_4/m1_6880_n1240# io_secondary_5p0_4/m1_n5943_7732#
+ m2_9867_1130# VSUBS io_secondary_5p0
.ends

.subckt io_secondary_5p0_array io_secondary_5p0_under_hierarchy_0/io_secondary_5p0_2/m1_6880_n1240#
+ io_secondary_5p0_under_hierarchy_0/io_secondary_5p0_3/m1_n5943_7732# io_secondary_5p0_under_hierarchy_0/io_secondary_5p0_0/m1_n5943_7732#
+ m2_11910_1130# io_secondary_5p0_under_hierarchy_0/io_secondary_5p0_4/m1_n5943_7732#
+ io_secondary_5p0_under_hierarchy_0/io_secondary_5p0_3/m1_6880_n1240# io_secondary_5p0_under_hierarchy_0/io_secondary_5p0_0/m1_6880_n1240#
+ io_secondary_5p0_under_hierarchy_0/io_secondary_5p0_1/m1_n5943_7732# io_secondary_5p0_under_hierarchy_0/io_secondary_5p0_4/m1_6880_n1240#
+ io_secondary_5p0_under_hierarchy_0/io_secondary_5p0_2/m1_n5943_7732# io_secondary_5p0_under_hierarchy_0/io_secondary_5p0_1/m1_6880_n1240#
+ VSUBS
Xio_secondary_5p0_under_hierarchy_0 io_secondary_5p0_under_hierarchy_0/io_secondary_5p0_1/m1_6880_n1240#
+ io_secondary_5p0_under_hierarchy_0/io_secondary_5p0_2/m1_6880_n1240# io_secondary_5p0_under_hierarchy_0/io_secondary_5p0_3/m1_n5943_7732#
+ io_secondary_5p0_under_hierarchy_0/io_secondary_5p0_0/m1_n5943_7732# io_secondary_5p0_under_hierarchy_0/io_secondary_5p0_4/m1_n5943_7732#
+ io_secondary_5p0_under_hierarchy_0/io_secondary_5p0_3/m1_6880_n1240# io_secondary_5p0_under_hierarchy_0/io_secondary_5p0_0/m1_6880_n1240#
+ io_secondary_5p0_under_hierarchy_0/io_secondary_5p0_1/m1_n5943_7732# m2_11910_1130#
+ io_secondary_5p0_under_hierarchy_0/io_secondary_5p0_4/m1_6880_n1240# VSUBS io_secondary_5p0_under_hierarchy_0/io_secondary_5p0_2/m1_n5943_7732#
+ io_secondary_5p0_under_hierarchy
.ends

.subckt Unnamed_e3a0da27 m4_n620_n620# m4_n500_n500#
X0 m4_n500_n500# m4_n620_n620# cap_mim_2f0_m4m5_noshield c_width=5u c_length=5u
.ends

.subckt cmirror_interdigitized a_n1412_n50# w_n2485_n1240# a_n2168_n570#
X0 a_n1412_n50# a_n2168_n570# w_n2485_n1240# w_n2485_n1240# pfet_03v3 ad=0.23p pd=1.42u as=0.23p ps=1.42u w=0.5u l=0.4u M=12
X1 w_n2485_n1240# a_n2168_n570# a_n2168_n570# w_n2485_n1240# pfet_03v3 ad=0.495p pd=2.98u as=0.23p ps=1.42u w=0.5u l=0.4u M=4
.ends

.subckt pmos_Cmirror_with_decap$1 I_BIAS cmirror_interdigitized_0/a_n1412_n50# Unnamed_e3a0da27_0/m4_n500_n500#
+ Unnamed_e3a0da27_0/m4_n620_n620#
XUnnamed_e3a0da27_0 Unnamed_e3a0da27_0/m4_n620_n620# Unnamed_e3a0da27_0/m4_n500_n500#
+ Unnamed_e3a0da27
Xcmirror_interdigitized_0 cmirror_interdigitized_0/a_n1412_n50# Unnamed_e3a0da27_0/m4_n500_n500#
+ Unnamed_e3a0da27_0/m4_n620_n620# cmirror_interdigitized
.ends

.subckt Unnamed_a96b0a34 m4_n620_n620# m4_n500_n500#
X0 m4_n500_n500# m4_n620_n620# cap_mim_2f0_m4m5_noshield c_width=5u c_length=5u
.ends

.subckt cmirror_interdigitized$4 a_n3932_n75# a_n4280_n495# a_n4540_n809#
X0 a_n4540_n809# a_n4280_n495# a_n4280_n495# a_n4540_n809# nfet_03v3 ad=0.345p pd=1.67u as=0.345p ps=1.67u w=0.75u l=1u M=20
X1 a_n3932_n75# a_n4280_n495# a_n4540_n809# a_n4540_n809# nfet_03v3 ad=0.345p pd=1.67u as=0.7425p ps=3.48u w=0.75u l=1u M=2
.ends

.subckt nmos4_Cmirror_with_decap via_array_6f2c13fe$7_0/m2_n100_n100# Unnamed_a96b0a34_0/m4_n620_n620#
+ VSUBS
XUnnamed_a96b0a34_0 Unnamed_a96b0a34_0/m4_n620_n620# VSUBS Unnamed_a96b0a34
Xcmirror_interdigitized$4_0 via_array_6f2c13fe$7_0/m2_n100_n100# Unnamed_a96b0a34_0/m4_n620_n620#
+ VSUBS cmirror_interdigitized$4
.ends

.subckt Unnamed_ba8f6150 m4_n620_n620# m4_n500_n500#
X0 m4_n500_n500# m4_n620_n620# cap_mim_2f0_m4m5_noshield c_width=5u c_length=5u
.ends

.subckt cmirror_interdigitized$2 a_n2410_n75# a_n2360_n495# a_n2620_n809#
X0 a_n2620_n809# a_n2360_n495# a_n2410_n75# a_n2620_n809# nfet_03v3 ad=0.345p pd=1.67u as=0.345p ps=1.67u w=0.75u l=1u M=10
X1 a_n2360_n495# a_n2360_n495# a_n2620_n809# a_n2620_n809# nfet_03v3 ad=0.345p pd=1.67u as=0.345p ps=1.67u w=0.75u l=1u M=2
.ends

.subckt nmos2_Cmirror_with_decap Unnamed_ba8f6150_0/m4_n620_n620# via_array_6f2c13fe$5_0/m2_200_n100#
+ VSUBS
XUnnamed_ba8f6150_0 Unnamed_ba8f6150_0/m4_n620_n620# VSUBS Unnamed_ba8f6150
Xcmirror_interdigitized$2_0 via_array_6f2c13fe$5_0/m2_200_n100# Unnamed_ba8f6150_0/m4_n620_n620#
+ VSUBS cmirror_interdigitized$2
.ends

.subckt Unnamed_2e9f948d m4_n620_n620# m4_n500_n500#
X0 m4_n500_n500# m4_n620_n620# cap_mim_2f0_m4m5_noshield c_width=5u c_length=5u
.ends

.subckt cmirror_interdigitized$3 a_n824_n495# a_n1084_n809# a_n874_n75#
X0 a_n874_n75# a_n824_n495# a_n1084_n809# a_n1084_n809# nfet_03v3 ad=0.7425p pd=3.48u as=0.345p ps=1.67u w=0.75u l=1u M=2
X1 a_n824_n495# a_n824_n495# a_n1084_n809# a_n1084_n809# nfet_03v3 ad=0.345p pd=1.67u as=0.345p ps=1.67u w=0.75u l=1u M=2
.ends

.subckt nmos3_Cmirror_with_decap via_array_6f2c13fe$5$1_0/m2_n100_n100# Unnamed_2e9f948d_0/m4_n620_n620#
+ VSUBS
XUnnamed_2e9f948d_0 Unnamed_2e9f948d_0/m4_n620_n620# VSUBS Unnamed_2e9f948d
Xcmirror_interdigitized$3_0 Unnamed_2e9f948d_0/m4_n620_n620# VSUBS via_array_6f2c13fe$5$1_0/m2_n100_n100#
+ cmirror_interdigitized$3
.ends

.subckt Unnamed_40a499cb m4_n620_n620# m4_n500_n500#
X0 m4_n500_n500# m4_n620_n620# cap_mim_2f0_m4m5_noshield c_width=5u c_length=5u
.ends

.subckt cmirror_interdigitized$1 a_n2410_n75# a_n2360_n495# a_n2620_n809#
X0 a_n2620_n809# a_n2360_n495# a_n2410_n75# a_n2620_n809# nfet_03v3 ad=0.345p pd=1.67u as=0.345p ps=1.67u w=0.75u l=1u M=10
X1 a_n2360_n495# a_n2360_n495# a_n2620_n809# a_n2620_n809# nfet_03v3 ad=0.345p pd=1.67u as=0.345p ps=1.67u w=0.75u l=1u M=2
.ends

.subckt nmos1_Cmirror_with_decap Unnamed_40a499cb_0/m4_n620_n620# via_array_6f2c13fe$3_0/m2_200_n100#
+ VSUBS
XUnnamed_40a499cb_0 Unnamed_40a499cb_0/m4_n620_n620# VSUBS Unnamed_40a499cb
Xcmirror_interdigitized$1_0 via_array_6f2c13fe$3_0/m2_200_n100# Unnamed_40a499cb_0/m4_n620_n620#
+ VSUBS cmirror_interdigitized$1
.ends

.subckt Biasing_Network nmos4_Cmirror_with_decap_0/via_array_6f2c13fe$7_0/m2_n100_n100#
+ nmos3_Cmirror_with_decap_0/via_array_6f2c13fe$5$1_0/m2_n100_n100# nmos2_Cmirror_with_decap_0/via_array_6f2c13fe$5_0/m2_200_n100#
+ m2_58818_n7812# nmos4_Cmirror_with_decap_0/Unnamed_a96b0a34_0/m4_n620_n620# pmos_Cmirror_with_decap$1_0/Unnamed_e3a0da27_0/m4_n620_n620#
+ m3_n9974_n6121# nmos1_Cmirror_with_decap_0/via_array_6f2c13fe$3_0/m2_200_n100# VSUBS
Xpmos_Cmirror_with_decap$1_0 pmos_Cmirror_with_decap$1_0/I_BIAS m3_n9974_n6121# m2_58818_n7812#
+ pmos_Cmirror_with_decap$1_0/Unnamed_e3a0da27_0/m4_n620_n620# pmos_Cmirror_with_decap$1
Xnmos4_Cmirror_with_decap_0 nmos4_Cmirror_with_decap_0/via_array_6f2c13fe$7_0/m2_n100_n100#
+ nmos4_Cmirror_with_decap_0/Unnamed_a96b0a34_0/m4_n620_n620# VSUBS nmos4_Cmirror_with_decap
Xnmos2_Cmirror_with_decap_0 m3_n9974_n6121# nmos2_Cmirror_with_decap_0/via_array_6f2c13fe$5_0/m2_200_n100#
+ VSUBS nmos2_Cmirror_with_decap
Xnmos3_Cmirror_with_decap_0 nmos3_Cmirror_with_decap_0/via_array_6f2c13fe$5$1_0/m2_n100_n100#
+ m3_n9974_n6121# VSUBS nmos3_Cmirror_with_decap
Xnmos1_Cmirror_with_decap_0 m3_n9974_n6121# nmos1_Cmirror_with_decap_0/via_array_6f2c13fe$3_0/m2_200_n100#
+ VSUBS nmos1_Cmirror_with_decap
.ends

.subckt LO_diff_pairs_interdigitized a_n2222_n400# a_n2878_n1500# a_n2578_n448# a_n2822_n400#
+ a_n3106_n400# a_n2522_n400# a_n3316_n1664#
X0 a_n2522_n400# a_n2578_n448# a_n2822_n400# a_n3316_n1664# nfet_03v3 ad=2.44p pd=5.22u as=2.44p ps=5.22u w=4u l=0.28u M=5
X1 a_n3106_n400# a_n2578_n448# a_n2222_n400# a_n3316_n1664# nfet_03v3 ad=2.44p pd=5.22u as=2.44p ps=5.22u w=4u l=0.28u M=5
X2 a_n2822_n400# a_n2878_n1500# a_n3106_n400# a_n3316_n1664# nfet_03v3 ad=2.44p pd=5.22u as=2.44p ps=5.22u w=4u l=0.28u M=5
X3 a_n2222_n400# a_n2878_n1500# a_n2522_n400# a_n3316_n1664# nfet_03v3 ad=2.44p pd=5.22u as=2.44p ps=5.22u w=4u l=0.28u M=5
.ends

.subckt RF_diff_pair$1 a_3384_n849# a_3440_n321# a_3156_n321# a_n628_n849# a_n572_n321#
+ a_n1750_n1013# a_n856_n321#
X0 a_n1750_n1013# a_n1750_n1013# a_n1750_n1013# a_n1750_n1013# nfet_03v3 ad=2.28p pd=6.28u as=18.24p ps=50.24u w=2u l=0.28u M=4
X1 a_n856_n321# a_n628_n849# a_n572_n321# a_n1750_n1013# nfet_03v3 ad=1.22p pd=3.22u as=1.22p ps=3.22u w=2u l=0.28u M=5
X2 a_3440_n321# a_3384_n849# a_3156_n321# a_n1750_n1013# nfet_03v3 ad=1.22p pd=3.22u as=2.28p ps=6.28u w=2u l=0.28u M=5
.ends

.subckt Gilbert_mixer_interdigited RF_diff_pair$1_0/a_n856_n321# RF_diff_pair$1_0/a_3384_n849#
+ RF_diff_pair$1_0/a_n628_n849# via_array_286f19cb$1_0/m2_n420_n210# via_array_6f2c13fe$2$2_0/m2_600_n100#
+ via_array_286f19cb_0/m2_n420_n210# via_array_6f2c13fe$3$2_0/m2_600_n100# RF_diff_pair$1_0/a_3440_n321#
+ VSUBS
XLO_diff_pairs_interdigitized_0 RF_diff_pair$1_0/a_3156_n321# via_array_286f19cb_0/m2_n420_n210#
+ via_array_286f19cb$1_0/m2_n420_n210# RF_diff_pair$1_0/a_n572_n321# via_array_6f2c13fe$2$2_0/m2_600_n100#
+ via_array_6f2c13fe$3$2_0/m2_600_n100# VSUBS LO_diff_pairs_interdigitized
XRF_diff_pair$1_0 RF_diff_pair$1_0/a_3384_n849# RF_diff_pair$1_0/a_3440_n321# RF_diff_pair$1_0/a_3156_n321#
+ RF_diff_pair$1_0/a_n628_n849# RF_diff_pair$1_0/a_n572_n321# VSUBS RF_diff_pair$1_0/a_n856_n321#
+ RF_diff_pair$1
.ends

.subckt Gilbert_mixer_layout V_IF_out V_LO V_RF V_LO_b V_RF_b VDD
XOutput_stage_0 V_IF_out VDD V_IF_out m3_453280_108358# Output_stage_0/m2_451_n2630#
+ Output_stage
XDegeneration_resistor_0 VDD Degeneration_resistor
XGilbert_mixer_loading_stage_0 m3_451768_108051# m3_451768_106738# VDD Gilbert_mixer_loading_stage
X4t-ota_0 VDD m3_454799_105309# m3_451768_106738# m3_451768_108051# m3_453280_108358#
+ VDD x4t-ota
Xio_secondary_5p0_array_0 V_LO_b m3_481277_87562# m3_402897_87612# VDD m3_504377_87383#
+ V_RF_b V_LO m3_424557_87585# m2_497668_69901# m3_459617_87585# V_RF VDD io_secondary_5p0_array
XBiasing_Network_0 Output_stage_0/m2_451_n2630# m3_454799_105309# m3_447543_98113#
+ VDD V_IF_out m3_504377_87383# V_IF_out m3_436631_98228# VDD Biasing_Network
XGilbert_mixer_interdigited_0 m3_436631_98228# m3_459617_87585# m3_424557_87585# m3_481277_87562#
+ m3_447251_106735# m3_402897_87612# m3_447251_108129# m3_447543_98113# VDD Gilbert_mixer_interdigited
.ends
